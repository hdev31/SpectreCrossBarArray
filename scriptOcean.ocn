simulator( 'spectre )
design(	 "/tp/xph2sei/xph2sei109/Labwork/Sim/mnist_grid_sim/spectre/config/netlist/netlist")
resultsDir( "/tp/xph2sei/xph2sei109/Labwork/Sim/mnist_grid_sim/spectre/config" )
modelFile(
    '("/softslin/AMS_410_ISR15/spectre/s35/cmos53.scs" "cmostm")
    '("/softslin/AMS_410_ISR15/spectre/s35/res.scs" "restm")
    '("/softslin/AMS_410_ISR15/spectre/s35/cap.scs" "captm")
    '("/softslin/AMS_410_ISR15/spectre/s35/vbic.scs" "biptm")
    '("/softslin/AMS_410_ISR15/spectre/s35/ind.scs" "indtm")
    '("/softslin/AMS_410_ISR15/spectre/s35/esddiode.scs" "esddiodetm")
)
definitionFile(
    "/softslin/AMS_410_ISR15/spectre/s35/soac.scs"
)
analysis('tran ?stop "10m"  )
envOption(
	'analysisOrder  list("tran")
)
option(	'additionalArgs  "dochecklimit=no"
)
saveOption( ?outputParamInfo t )
saveOption( ?elementInfo t )
saveOption( ?modelParamInfo t )
save( 'i "/I0/COL_099" "/I0/COL_098" "/I0/COL_097" "/I0/COL_096" "/I0/COL_095" "/I0/COL_094" "/I0/COL_093" "/I0/COL_092" "/I0/COL_091" "/I0/COL_090" "/I0/COL_089" "/I0/COL_088" "/I0/COL_087" "/I0/COL_086" "/I0/COL_085" "/I0/COL_084" "/I0/COL_083" "/I0/COL_082" "/I0/COL_081" "/I0/COL_080" "/I0/COL_079" "/I0/COL_078" "/I0/COL_077" "/I0/COL_076" "/I0/COL_075" "/I0/COL_074" "/I0/COL_073" "/I0/COL_072" "/I0/COL_071" "/I0/COL_070" "/I0/COL_069" "/I0/COL_068" "/I0/COL_067" "/I0/COL_066" "/I0/COL_065" "/I0/COL_064" "/I0/COL_063" "/I0/COL_062" "/I0/COL_061" "/I0/COL_060" "/I0/COL_059" "/I0/COL_058" "/I0/COL_057" "/I0/COL_056" "/I0/COL_055" "/I0/COL_054" "/I0/COL_053" "/I0/COL_052" "/I0/COL_051" "/I0/COL_050" "/I0/COL_049" "/I0/COL_048" "/I0/COL_047" "/I0/COL_046" "/I0/COL_045" "/I0/COL_044" "/I0/COL_043" "/I0/COL_042" "/I0/COL_041" "/I0/COL_040" "/I0/COL_039" "/I0/COL_038" "/I0/COL_037" "/I0/COL_036" "/I0/COL_035" "/I0/COL_034" "/I0/COL_033" "/I0/COL_032" "/I0/COL_031" "/I0/COL_030" "/I0/COL_029" "/I0/COL_028" "/I0/COL_027" "/I0/COL_026" "/I0/COL_025" "/I0/COL_024" "/I0/COL_023" "/I0/COL_022" "/I0/COL_021" "/I0/COL_020" "/I0/COL_019" "/I0/COL_018" "/I0/COL_017" "/I0/COL_016" "/I0/COL_015" "/I0/COL_014" "/I0/COL_013" "/I0/COL_012" "/I0/COL_011" "/I0/COL_010" "/I0/COL_009" "/I0/COL_008" "/I0/COL_007" "/I0/COL_006" "/I0/COL_005" "/I0/COL_004" "/I0/COL_003" "/I0/COL_002" "/I0/COL_001" "/I0/COL_000" "/I0/COLN_099" "/I0/COLN_098" "/I0/COLN_097" "/I0/COLN_096" "/I0/COLN_095" "/I0/COLN_094" "/I0/COLN_093" "/I0/COLN_092" "/I0/COLN_091" "/I0/COLN_090" "/I0/COLN_089" "/I0/COLN_088" "/I0/COLN_087" "/I0/COLN_086" "/I0/COLN_085" "/I0/COLN_084" "/I0/COLN_083" "/I0/COLN_082" "/I0/COLN_081" "/I0/COLN_080" "/I0/COLN_079" "/I0/COLN_078" "/I0/COLN_077" "/I0/COLN_076" "/I0/COLN_075" "/I0/COLN_074" "/I0/COLN_073" "/I0/COLN_072" "/I0/COLN_071" "/I0/COLN_070" "/I0/COLN_069" "/I0/COLN_068" "/I0/COLN_067" "/I0/COLN_066" "/I0/COLN_065" "/I0/COLN_064" "/I0/COLN_063" "/I0/COLN_062" "/I0/COLN_061" "/I0/COLN_060" "/I0/COLN_059" "/I0/COLN_058" "/I0/COLN_057" "/I0/COLN_056" "/I0/COLN_055" "/I0/COLN_054" "/I0/COLN_053" "/I0/COLN_052" "/I0/COLN_051" "/I0/COLN_050" "/I0/COLN_049" "/I0/COLN_048" "/I0/COLN_047" "/I0/COLN_046" "/I0/COLN_045" "/I0/COLN_044" "/I0/COLN_043" "/I0/COLN_042" "/I0/COLN_041" "/I0/COLN_040" "/I0/COLN_039" "/I0/COLN_038" "/I0/COLN_037" "/I0/COLN_036" "/I0/COLN_035" "/I0/COLN_034" "/I0/COLN_033" "/I0/COLN_032" "/I0/COLN_031" "/I0/COLN_030" "/I0/COLN_029" "/I0/COLN_028" "/I0/COLN_027" "/I0/COLN_026" "/I0/COLN_025" "/I0/COLN_024" "/I0/COLN_023" "/I0/COLN_022" "/I0/COLN_021" "/I0/COLN_020" "/I0/COLN_019" "/I0/COLN_018" "/I0/COLN_017" "/I0/COLN_016" "/I0/COLN_015" "/I0/COLN_014" "/I0/COLN_013" "/I0/COLN_012" "/I0/COLN_011" "/I0/COLN_010" "/I0/COLN_009" "/I0/COLN_008" "/I0/COLN_007" "/I0/COLN_006" "/I0/COLN_005" "/I0/COLN_004" "/I0/COLN_003" "/I0/COLN_002" "/I0/COLN_001" "/I0/COLN_000" )
temp( 27 )
run()
selectResult( 'tran )
outputs()

ocnPrint(?output "/tp/xph2sei/xph2sei109/Labwork/mnist_test/positivecurrent.txt" ?step 1m ?numSpaces 1 ?precision 5 ?numberNotation 'none i("/I0/COL_000")
i("/I0/COL_001")
i("/I0/COL_002")
i("/I0/COL_003")
i("/I0/COL_004")
i("/I0/COL_005")
i("/I0/COL_006")
i("/I0/COL_007")
i("/I0/COL_008")
i("/I0/COL_009")
i("/I0/COL_010")
i("/I0/COL_011")
i("/I0/COL_012")
i("/I0/COL_013")
i("/I0/COL_014")
i("/I0/COL_015")
i("/I0/COL_016")
i("/I0/COL_017")
i("/I0/COL_018")
i("/I0/COL_019")
i("/I0/COL_020")
i("/I0/COL_021")
i("/I0/COL_022")
i("/I0/COL_023")
i("/I0/COL_024")
i("/I0/COL_025")
i("/I0/COL_026")
i("/I0/COL_027")
i("/I0/COL_028")
i("/I0/COL_029")
i("/I0/COL_030")
i("/I0/COL_031")
i("/I0/COL_032")
i("/I0/COL_033")
i("/I0/COL_034")
i("/I0/COL_035")
i("/I0/COL_036")
i("/I0/COL_037")
i("/I0/COL_038")
i("/I0/COL_039")
i("/I0/COL_040")
i("/I0/COL_041")
i("/I0/COL_042")
i("/I0/COL_043")
i("/I0/COL_044")
i("/I0/COL_045")
i("/I0/COL_046")
i("/I0/COL_047")
i("/I0/COL_048")
i("/I0/COL_049")
i("/I0/COL_050")
i("/I0/COL_051")
i("/I0/COL_052")
i("/I0/COL_053")
i("/I0/COL_054")
i("/I0/COL_055")
i("/I0/COL_056")
i("/I0/COL_057")
i("/I0/COL_058")
i("/I0/COL_059")
i("/I0/COL_060")
i("/I0/COL_061")
i("/I0/COL_062")
i("/I0/COL_063")
i("/I0/COL_064")
i("/I0/COL_065")
i("/I0/COL_066")
i("/I0/COL_067")
i("/I0/COL_068")
i("/I0/COL_069")
i("/I0/COL_070")
i("/I0/COL_071")
i("/I0/COL_072")
i("/I0/COL_073")
i("/I0/COL_074")
i("/I0/COL_075")
i("/I0/COL_076")
i("/I0/COL_077")
i("/I0/COL_078")
i("/I0/COL_079")
i("/I0/COL_080")
i("/I0/COL_081")
i("/I0/COL_082")
i("/I0/COL_083")
i("/I0/COL_084")
i("/I0/COL_085")
i("/I0/COL_086")
i("/I0/COL_087")
i("/I0/COL_088")
i("/I0/COL_089")
i("/I0/COL_090")
i("/I0/COL_091")
i("/I0/COL_092")
i("/I0/COL_093")
i("/I0/COL_094")
i("/I0/COL_095")
i("/I0/COL_096")
i("/I0/COL_097")
i("/I0/COL_098")
i("/I0/COL_099")
 )

ocnPrint(?output "/tp/xph2sei/xph2sei109/Labwork/mnist_test/negativecurrent.txt" ?step 1m ?numSpaces 1 ?precision 5 ?numberNotation 'none i("/I0/COLN_000")
i("/I0/COLN_001")
i("/I0/COLN_002")
i("/I0/COLN_003")
i("/I0/COLN_004")
i("/I0/COLN_005")
i("/I0/COLN_006")
i("/I0/COLN_007")
i("/I0/COLN_008")
i("/I0/COLN_009")
i("/I0/COLN_010")
i("/I0/COLN_011")
i("/I0/COLN_012")
i("/I0/COLN_013")
i("/I0/COLN_014")
i("/I0/COLN_015")
i("/I0/COLN_016")
i("/I0/COLN_017")
i("/I0/COLN_018")
i("/I0/COLN_019")
i("/I0/COLN_020")
i("/I0/COLN_021")
i("/I0/COLN_022")
i("/I0/COLN_023")
i("/I0/COLN_024")
i("/I0/COLN_025")
i("/I0/COLN_026")
i("/I0/COLN_027")
i("/I0/COLN_028")
i("/I0/COLN_029")
i("/I0/COLN_030")
i("/I0/COLN_031")
i("/I0/COLN_032")
i("/I0/COLN_033")
i("/I0/COLN_034")
i("/I0/COLN_035")
i("/I0/COLN_036")
i("/I0/COLN_037")
i("/I0/COLN_038")
i("/I0/COLN_039")
i("/I0/COLN_040")
i("/I0/COLN_041")
i("/I0/COLN_042")
i("/I0/COLN_043")
i("/I0/COLN_044")
i("/I0/COLN_045")
i("/I0/COLN_046")
i("/I0/COLN_047")
i("/I0/COLN_048")
i("/I0/COLN_049")
i("/I0/COLN_050")
i("/I0/COLN_051")
i("/I0/COLN_052")
i("/I0/COLN_053")
i("/I0/COLN_054")
i("/I0/COLN_055")
i("/I0/COLN_056")
i("/I0/COLN_057")
i("/I0/COLN_058")
i("/I0/COLN_059")
i("/I0/COLN_060")
i("/I0/COLN_061")
i("/I0/COLN_062")
i("/I0/COLN_063")
i("/I0/COLN_064")
i("/I0/COLN_065")
i("/I0/COLN_066")
i("/I0/COLN_067")
i("/I0/COLN_068")
i("/I0/COLN_069")
i("/I0/COLN_070")
i("/I0/COLN_071")
i("/I0/COLN_072")
i("/I0/COLN_073")
i("/I0/COLN_074")
i("/I0/COLN_075")
i("/I0/COLN_076")
i("/I0/COLN_077")
i("/I0/COLN_078")
i("/I0/COLN_079")
i("/I0/COLN_080")
i("/I0/COLN_081")
i("/I0/COLN_082")
i("/I0/COLN_083")
i("/I0/COLN_084")
i("/I0/COLN_085")
i("/I0/COLN_086")
i("/I0/COLN_087")
i("/I0/COLN_088")
i("/I0/COLN_089")
i("/I0/COLN_090")
i("/I0/COLN_091")
i("/I0/COLN_092")
i("/I0/COLN_093")
i("/I0/COLN_094")
i("/I0/COLN_095")
i("/I0/COLN_096")
i("/I0/COLN_097")
i("/I0/COLN_098")
i("/I0/COLN_099") )
exit()
